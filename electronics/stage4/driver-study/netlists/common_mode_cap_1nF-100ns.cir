SCCI_RH S4 restricted closed-loop current-driver surrogate
Vhv hv 0 24
Vset set 0 0.29998779296875
.model BR SW(Ron=10 Roff=1e12 Vt=1.65 Vh=0)
.model MX SW(Ron=2 Roff=1e12 Vt=1.65 Vh=0)
.model FET NMOS(Level=1 Vto=1.3 Kp=0.05 Lambda=0.005)
.model CLAMP D(Is=1e-12 N=1 Rs=1)
Vplus0 cp0 0 PWL(0 0 0.0004 0 0.000400001 3.3 0.0006 3.3 0.000600001 0)
Vminus0 cm0 0 PWL(0 0 0.0007 0 0.000700001 3.3 0.0009 3.3 0.000900001 0)
Brun0 run0 0 V={max(v(cp0),v(cm0))}
Boff0 off0 0 V={3.3-v(run0)}
Bfbctl0 fc0 0 V={v(run0)}
Bfboff0 foff0 0 V={3.3-v(fc0)}
S1_0 hv a0 cp0 0 BR
S4_0 dr0 br0 cp0 0 BR
S2_0 hv br0 cm0 0 BR
S3_0 dr0 a0 cm0 0 BR
Rpair0 a0 pol0 1000
Cpol0 pol0 ret0 2e-06 IC=0
Rpol0 pol0 ret0 100k
Rshunt0 ret0 br0 2
Rfeedback0 sense0 0 100
Rgate0 muxg0 gate0 330
Rpull0 gate0 0 100k
Cgs0 gate0 sense0 7e-11
Cgd0 gate0 dr0 10p
Cds0 dr0 sense0 1.2p
Sgate_on0 amp0 muxg0 run0 0 MX
Sgate_off0 0 muxg0 off0 0 MX
Sfeedback_on0 sense0 fb0 fc0 0 MX
Sfeedback_off0 amp0 fb0 foff0 0 MX
Cinput0 fb0 0 5p IC=0.29998779296875
Rinput0 fb0 0 1e9
IBload0 ret0 0 0
IBbridge0 br0 0 0
Ccommon0 ret0 0 1e-09 IC=0
Rret0 ret0 0 1e12
Rdr0 dr0 0 1e12
Ra0 a0 0 1e12
Mdriver0 dr0 gate0 sense0 sense0 FET W=1 L=1
Bamp0 0 state0 I={1e-9*(v(state0)>14.95 ? min(0,(max(-20000000,min(20000000,62831853.0717959*(v(set)-v(fb0))))-628.318530717959*v(state0))) : (v(state0)<0.05 ? max(0,(max(-20000000,min(20000000,62831853.0717959*(v(set)-v(fb0))))-628.318530717959*v(state0))) : (max(-20000000,min(20000000,62831853.0717959*(v(set)-v(fb0))))-628.318530717959*v(state0))))}
Cdom0 state0 0 1n IC=0.29998779296875
Bout0 amp0 0 V={max(0.05,min(14.95,v(state0)))}
Dhi_a0 a0 hv CLAMP
Dlo_a0 0 a0 CLAMP
Dhi_br0 br0 hv CLAMP
Dlo_br0 0 br0 CLAMP
Dhi_dr0 dr0 hv CLAMP
Dlo_dr0 0 dr0 CLAMP
Vplus1 cp1 0 PWL(0 0 0.000425 0 0.000425001 3.3 0.000625 3.3 0.000625001 0)
Vminus1 cm1 0 PWL(0 0 0.000725 0 0.000725001 3.3 0.000925 3.3 0.000925001 0)
Brun1 run1 0 V={max(v(cp1),v(cm1))}
Boff1 off1 0 V={3.3-v(run1)}
Bfbctl1 fc1 0 V={v(run1)}
Bfboff1 foff1 0 V={3.3-v(fc1)}
S1_1 hv a1 cp1 0 BR
S4_1 dr1 br1 cp1 0 BR
S2_1 hv br1 cm1 0 BR
S3_1 dr1 a1 cm1 0 BR
Rpair1 a1 pol1 1000
Cpol1 pol1 ret1 2e-06 IC=0
Rpol1 pol1 ret1 100k
Rshunt1 ret1 br1 2
Rfeedback1 sense1 0 100
Rgate1 muxg1 gate1 330
Rpull1 gate1 0 100k
Cgs1 gate1 sense1 7e-11
Cgd1 gate1 dr1 10p
Cds1 dr1 sense1 1.2p
Sgate_on1 amp1 muxg1 run1 0 MX
Sgate_off1 0 muxg1 off1 0 MX
Sfeedback_on1 sense1 fb1 fc1 0 MX
Sfeedback_off1 amp1 fb1 foff1 0 MX
Cinput1 fb1 0 5p IC=0.29998779296875
Rinput1 fb1 0 1e9
IBload1 ret1 0 0
IBbridge1 br1 0 0
Ccommon1 ret1 0 1e-09 IC=0
Rret1 ret1 0 1e12
Rdr1 dr1 0 1e12
Ra1 a1 0 1e12
Mdriver1 dr1 gate1 sense1 sense1 FET W=1 L=1
Bamp1 0 state1 I={1e-9*(v(state1)>14.95 ? min(0,(max(-20000000,min(20000000,62831853.0717959*(v(set)-v(fb1))))-628.318530717959*v(state1))) : (v(state1)<0.05 ? max(0,(max(-20000000,min(20000000,62831853.0717959*(v(set)-v(fb1))))-628.318530717959*v(state1))) : (max(-20000000,min(20000000,62831853.0717959*(v(set)-v(fb1))))-628.318530717959*v(state1))))}
Cdom1 state1 0 1n IC=0.29998779296875
Bout1 amp1 0 V={max(0.05,min(14.95,v(state1)))}
Dhi_a1 a1 hv CLAMP
Dlo_a1 0 a1 CLAMP
Dhi_br1 br1 hv CLAMP
Dlo_br1 0 br1 CLAMP
Dhi_dr1 dr1 hv CLAMP
Dlo_dr1 0 dr1 CLAMP
.options reltol=1e-8 abstol=1e-13 vntol=1e-10 method=gear
.save v(a0) v(pol0) v(ret0) v(br0) v(dr0) v(sense0) v(gate0) v(amp0) v(run0) v(a1) v(pol1) v(ret1) v(br1) v(dr1) v(sense1) v(gate1) v(amp1) v(run1)
.tran 1e-07 0.0014 0 1e-07 UIC
.end
